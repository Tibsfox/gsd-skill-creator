* Explorer 7 — Suomi-Parent Bolometer Model
* =========================================================================
* Mission 1.12 — Explorer 7 (Goddard SFC / Juno II), October 13, 1959
* THERMISTOR-BASED BOLOMETER — Radiation Measurement via Temperature
*
* The Suomi-Parent bolometer measures radiation by detecting the
* temperature change it causes in a thermal mass. This SPICE model
* uses the thermal-electrical analogy:
*
*   Thermal              Electrical
*   ----------           ----------
*   Heat flow (W)    →   Current (A)
*   Temperature (K)  →   Voltage (V)
*   Thermal mass (J/K) → Capacitance (F)
*   Thermal resistance → Resistance (Ω)
*   Radiation input   →  Current source
*
* The bolometer sensor is modeled as:
*   - A thermal capacitance (the sensor's heat capacity)
*   - A thermal resistance to space (radiative cooling)
*   - A radiation input (current source modulated by orbit position)
*   - A Wheatstone bridge read-out circuit converts temperature
*     (modeled as voltage) to an output signal
*
* Two bolometers are simulated:
*   1. Black hemisphere — absorbs all wavelengths
*   2. White hemisphere — reflects visible, absorbs infrared
*
* The difference between the two outputs isolates the solar component
* from the thermal component — Suomi's key measurement principle.
*
* Run: ngspice -b bolometer.cir
* =========================================================================

.title Explorer 7 — Suomi-Parent Bolometer (Thermal-Electrical Analogy)

* =========================================================================
* RADIATION INPUT — Orbital Modulation
* =========================================================================
* The radiation input varies around the orbit:
*   - Full sun: maximum input (solar + Earth thermal + reflected)
*   - Eclipse: minimum input (Earth thermal only)
*   - Transition: gradual change at terminator
*
* Modeled as a pulsed current source:
*   Period = 101.2 minutes = 6072 seconds (one orbit)
*   Sunlit duration ≈ 60 minutes = 3600 seconds
*   Eclipse duration ≈ 41 minutes = 2460 seconds

* --- Black bolometer radiation input ---
* Full sun: solar (340) + reflected (30) + thermal (60) = 430 W/m² equiv
* Eclipse: thermal only (60 W/m² equiv)
* Modeled as: baseline 60 mA + pulse of 370 mA during sunlit

I_rad_black 0 bk_therm DC 0.060 PULSE(0.060 0.430 0 120 120 3600 6072)

* Thermal capacitance — sensor heat capacity
* Black hemisphere: ~2 J/K (small, lightweight sensor)
C_bk bk_therm 0 2 IC=0.260

* Thermal resistance to space — radiative cooling
* R_rad = 1/(4*epsilon*sigma*A*T^3) ≈ 100 K/W for small sensor
R_bk_rad bk_therm 0 100

* --- White bolometer radiation input ---
* Full sun: solar*0.1 (34) + reflected*0.1 (3) + thermal (60) = 97 W/m² equiv
* Eclipse: thermal only (60 W/m² equiv)
* White hemisphere reflects ~90% of visible → absorbs only ~10%

I_rad_white 0 wh_therm DC 0.060 PULSE(0.060 0.097 0 120 120 3600 6072)

* White hemisphere thermal capacitance (same mass)
C_wh wh_therm 0 2 IC=0.240

* White hemisphere thermal resistance
R_wh_rad wh_therm 0 110

* =========================================================================
* BRIDGE READOUT — Wheatstone Bridge Output
* =========================================================================
* The bolometer temperature (voltage) drives a thermistor model.
* The bridge converts small temperature changes to measurable voltage.
*
* Simplified: the bridge output is proportional to (T_black - T_white)

* Voltage-controlled voltage source: amplifies the difference
* (Bolometer difference → telemetry signal)
E_diff bridge_out 0 bk_therm wh_therm 10

* Load resistance (telemetry input impedance)
R_bridge bridge_out 0 1k

* =========================================================================
* STEP RESPONSE — Sudden radiation change
* =========================================================================
* Additional simulation: what happens when the satellite enters/exits
* eclipse — a step change in radiation input.
*
* This shows the thermal time constant of the bolometer: how fast
* it responds to a change in radiation.

* Step source for response test
I_step 0 step_therm PULSE(0.060 0.430 0.5 0.001 0.001 3 20)

* Same thermal properties as black bolometer
C_step step_therm 0 2 IC=0.260
R_step step_therm 0 100

* =========================================================================
* ANALYSIS
* =========================================================================

* Transient: 2 full orbits (12144 seconds ≈ 3.37 hours)
.tran 10 12144 0 10

.control
  run

  set color0 = white
  set color1 = rgb:cc:40:20
  set color2 = rgb:e8:d0:60
  set color3 = rgb:20:40:aa
  set color4 = rgb:8a:aa:70

  * --- Plot 1: Bolometer temperatures (voltages) over two orbits ---
  plot v(bk_therm) v(wh_therm) title 'Bolometer Temperatures: Black (red) vs White (yellow)' xlabel 'Time (s)' ylabel 'Temperature (analogy: V = K/1000)'

  * --- Plot 2: Bridge output (difference signal) ---
  plot v(bridge_out) title 'Bridge Output: T_black - T_white (amplified)' xlabel 'Time (s)' ylabel 'Difference Signal (V)'

  * --- Plot 3: Step response (eclipse entry/exit) ---
  plot v(step_therm) title 'Bolometer Step Response (Eclipse Transition)' xlabel 'Time (s)' ylabel 'Temperature Response'

  * --- Plot 4: Radiation inputs ---
  plot @i_rad_black[c] @i_rad_white[c] title 'Radiation Input: Black vs White Bolometer' xlabel 'Time (s)' ylabel 'Radiation (analogy: mA = W/m²)'

  * Measurements
  meas tran bk_max max v(bk_therm) from=3000 to=6072
  meas tran bk_min min v(bk_therm) from=3000 to=6072
  meas tran wh_max max v(wh_therm) from=3000 to=6072
  meas tran wh_min min v(wh_therm) from=3000 to=6072

  * Time constant from step response
  let bk_63 = 0.260 + 0.63 * (0.430 * 100 - 0.260)
  meas tran tau_rise trig v(step_therm) val=0.260 rise=1 targ v(step_therm) val=0.37 rise=1

  echo ""
  echo "========================================="
  echo "Suomi-Parent Bolometer Analysis"
  echo "========================================="
  echo "Black bolometer T range: $&bk_min to $&bk_max (V ≈ K/1000)"
  echo "White bolometer T range: $&wh_min to $&wh_max (V ≈ K/1000)"
  echo ""
  echo "Temperature swing (black): over one orbit"
  echo "Temperature swing (white): smaller — thermal only"
  echo ""
  echo "Suomi's insight: the DIFFERENCE between black"
  echo "and white isolates the solar component from"
  echo "the thermal component. This is the first"
  echo "radiation budget measurement from space."
  echo "========================================="

.endc

.end
