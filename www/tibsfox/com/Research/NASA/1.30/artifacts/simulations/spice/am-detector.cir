* AM Detector — Envelope Detector Circuit
* Radio Receiver Series v1.30
* Germanium diode envelope detector for AM demodulation
*
* Input: 455 kHz IF signal, AM modulated with 1 kHz audio
* Output: Demodulated audio envelope
*
* Circuit: 1N34A germanium diode + RC low-pass filter
*
* Connection to Ranger 5:
* The detector extracts information from carrier.
* Ranger 5's carrier had no information to extract.

* === SIGNAL SOURCE ===
* 455 kHz carrier, 80% AM modulated at 1 kHz
* V_am = V_carrier * (1 + m * sin(2*pi*f_audio*t)) * sin(2*pi*f_carrier*t)
V1 carrier 0 SIN(0 0.5 455k 0 0) ; carrier
V2 mod 0 SIN(0 0.4 1k 0 0)      ; modulation (80% depth)
B1 input 0 V = V(carrier) * (1 + V(mod))

* === DETECTOR CIRCUIT ===
* 1N34A Germanium Diode
D1 input detected D1N34A
.model D1N34A D(Is=2.5e-7 Rs=7 N=1.1 BV=60 IBV=1e-7 CJ0=0.5e-12)

* RC Low-Pass Filter (envelope detector)
* tau = R*C = 47k * 100p = 4.7 us
* f_cutoff = 1/(2*pi*tau) = 33.9 kHz
* Passes audio (<5 kHz), attenuates carrier (455 kHz)
R1 detected output 47k
C1 output 0 100p

* Load resistor (simulating crystal earphone impedance)
R2 output 0 100k

* === ANALYSIS ===
.tran 0.5u 5m          ; 5 ms transient, 0.5 us step
.control
run
* Plot input AM signal and detected envelope
plot V(input) V(output)
.endc

.end
