* AM Envelope Detector — Radio Series v1.29
* Mission 1.29 — Ranger 4
* ngspice netlist
*
* Germanium diode (1N34A) envelope detector
* Extracts audio from AM-modulated IF carrier
* When carrier is unmodulated: DC output only (silence)
*
* Demonstrates what the DSN heard from Ranger 4:
* a carrier with no information.

* === Circuit Parameters ===
.param f_carrier = 455k    ; IF carrier frequency (from v1.28)
.param f_audio = 1k        ; Audio modulation frequency
.param v_carrier = 0.5     ; Carrier amplitude (V)
.param m_depth = 0.8       ; Modulation depth (0-1)

* === AM Source (modulated carrier) ===
* V_AM = V_c * (1 + m * sin(2*pi*f_audio*t)) * sin(2*pi*f_carrier*t)
V_in in 0 SIN(0 {v_carrier} {f_carrier}) AM({m_depth} {f_audio})

* === Envelope Detector ===
* D1: 1N34A germanium diode
D1 in det D1N34A
.model D1N34A D(Is=2.6e-7 Rs=7 N=1.6 BV=60 Ibv=1e-8 Cjo=0.18p Vj=0.3 M=0.5)

* R1: Load resistor (10K)
R1 det 0 10k

* C1: Filter capacitor (100 pF)
C1 det 0 100p

* === DC Blocking + Audio Output ===
* C2: Coupling capacitor (0.01 uF)
C2 det audio 10n

* R2: Audio load (100K — crystal earpiece impedance)
R2 audio 0 100k

* R3: DC return path
R3 in 0 100k

* === Analysis ===
.tran 1u 5m            ; Transient: 1us step, 5ms duration
.control
  run

  * Plot carrier + detected envelope
  plot v(in) v(det) v(audio)

  * Measure DC level (should be ~0.15V for modulated, same for unmodulated)
  meas tran v_dc avg v(det) from=2m to=5m

  * Measure audio amplitude (should be ~0 for unmodulated carrier)
  meas tran v_audio_pp pp v(audio) from=2m to=5m

  echo "=== Ranger 4 AM Detector ==="
  echo "With modulation: audio output is present (v_audio_pp > 0)"
  echo "Without modulation: audio output is zero (carrier only)"
  echo "This is what the DSN heard: a carrier with nothing on it."
.endc

.end
