* LC Filter Stage — Transient Suppression
* Mission 1.33 — Ranger 6 (Atlas-Agena B)
* Radio Series: Power supply filter
*
* This circuit demonstrates the LC low-pass filter principle
* that was missing on Ranger 6's camera power bus.
* The filter blocks high-frequency transients (like the Atlas
* staging transient) while passing DC power.
*
* The staging transient was a microsecond-scale pulse that
* coupled into the camera power bus. An LC filter with cutoff
* well below the transient frequency would have blocked it.
*
* Circuit: Series inductor + shunt capacitor
*   - L = 100 µH (series, blocks HF current)
*   - C = 100 nF (shunt, diverts HF to ground)
*   - Cutoff frequency: f_c = 1/(2π√LC) ≈ 50 kHz
*   - The staging transient had frequency content >1 MHz
*   - Attenuation at 1 MHz: ~26 dB (20× reduction)
*
* Test: Apply a voltage spike simulating the staging transient
* and observe filtered vs unfiltered output.

.title Ranger 6 EMC Fix — LC Filter Stage

* Power supply (12V DC)
V_supply 1 0 DC 12V

* Staging transient (superimposed on DC)
* 500V pulse, 1µs duration, at t=1ms
V_transient 1 2 PULSE(0 500 1ms 100ns 100ns 1us 100ms)

* === UNFILTERED PATH (Ranger 6 — cameras killed) ===
R_unfilt 2 3 10
R_load1 3 0 1k

* === FILTERED PATH (Ranger 7 — cameras survived) ===
* Series inductor
L_filter 2 4 100uH
* Shunt capacitor
C_filter 4 0 100nF
* Load
R_load2 4 0 1k

* Simulation
.tran 0.1us 5ms 0.9ms 0.1us

* Measurements
.meas tran V_unfilt_peak MAX V(3)
.meas tran V_filt_peak MAX V(4)
.meas tran V_unfilt_dc AVG V(3) FROM=0ms TO=0.9ms
.meas tran V_filt_dc AVG V(4) FROM=0ms TO=0.9ms

.control
run
set hcopypscolor = 1
set color0 = rgb:0d/0a/08
set color1 = rgb:e8/e8/e8
hardcopy lc_filter_output.ps v(3) v(4)
echo "=== Ranger 6 LC Filter Analysis ==="
echo "Unfiltered peak (cameras killed): $&V_unfilt_peak V"
echo "Filtered peak (cameras survived): $&V_filt_peak V"
echo "Attenuation: significant reduction of transient"
echo ""
echo "A $0.50 inductor and a $0.10 capacitor."
echo "That is what was missing on Ranger 6."
.endc

.end
