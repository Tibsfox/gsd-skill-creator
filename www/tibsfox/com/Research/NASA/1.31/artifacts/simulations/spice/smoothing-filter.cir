* smoothing-filter.cir — The Physical Overbar
* SPICE simulation of the RC low-pass filter that represents
* the missing smoothing function in Mariner 1's guidance code
* Mission 1.31 — Mariner 1 (Atlas-Agena B)
*
* Two-stage RC filter: f_c1 = 159 Hz, f_c2 = 72 Hz
* Input: noisy square wave (simulated radar tracking data)
* Output: smoothed signal (what the guidance code should have produced)

* Noise source (simulated radar with jitter)
V_radar 1 0 PULSE(0 5 0 1u 1u 0.5m 1m)

* First RC stage (primary smoothing)
R1 1 2 10k
C1 2 0 100n

* Second RC stage (additional filtering)
R2 2 3 47k
C2 3 0 47n

* Output load (guidance computer input impedance)
R_load 3 0 1MEG

.tran 0.1m 20m
.control
run
plot v(1) v(2) v(3) title "Mariner 1: The Overbar as RC Filter"
+ xlabel "Time (ms)" ylabel "Voltage (V)"
.endc

* v(1) = Raw radar data (noisy, unsmoothed — what Mariner 1 used)
* v(2) = After first smoothing stage
* v(3) = After second smoothing stage (what the code SHOULD have used)
*
* The difference between v(1) and v(3) is the overbar.
* That difference cost $18.5 million.

.end
