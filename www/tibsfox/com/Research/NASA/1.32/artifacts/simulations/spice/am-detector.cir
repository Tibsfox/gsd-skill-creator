* AM Envelope Detector — Mission 1.32 Radio Series
* Simple diode detector for 455 kHz AM signal
* Extracts audio envelope from IF amplifier output
*
* This is the detector stage of the superheterodyne receiver:
*   v1.4 mixer → v1.5 IF amplifier → v1.32 AM detector
*
* Mariner 2's telemetry was FM (not AM), but the detection
* principle is the same: extract the modulating signal from
* the carrier using nonlinear processing.

.title AM Envelope Detector (455 kHz IF)

* Signal source: 455 kHz carrier, 1 kHz AM modulation
V1 in 0 AM(0.5 455k 1k 0.8)

* Germanium diode (1N34A equivalent)
D1 in out GEDIODE
.model GEDIODE D(Is=200u Rs=10 N=1.3 BV=75 Cjo=1p)

* RC filter: 10nF + 10K
C1 out 0 10n
R1 out 0 10k

* Audio coupling capacitor
C2 out audio 100n
R2 audio 0 47k

.tran 0.5u 5m
.control
run
plot v(in) v(out) v(audio)
.endc

.end
