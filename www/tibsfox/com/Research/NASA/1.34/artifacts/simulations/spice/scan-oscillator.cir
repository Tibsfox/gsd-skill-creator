* Ranger 7 Horizontal Scan Oscillator
* Mission 1.34 — NASA Mission Series
*
* The vidicon electron beam is swept horizontally by a sawtooth
* waveform. This circuit generates the horizontal scan timing
* for the F-channel (1150 lines in 2.56 seconds).
*
* Scan frequency: 1150 / 2.56 = 449.2 Hz (approximate)
*
.title Ranger 7 Horizontal Scan Oscillator

VCC 1 0 DC 12V

* 555 timer in astable mode for scan timing
* Frequency ≈ 1.44 / ((R1 + 2*R2) * C)
* Target: ~449 Hz

R1 1 2 1.5k
R2 2 3 1.5k
C1 3 0 470n

* 555 approximation (simplified)
X1 1 2 3 4 0 NE555

* Output sawtooth shaping
R_out 4 5 10k
C_out 5 0 100n

.tran 10u 10m
.end
