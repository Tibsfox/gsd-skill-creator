* Reaction Time Measurement Circuit
* ==================================
* NASA Mission Series v1.17
*
* Models a simple analog circuit for measuring reaction time
* using RC charging. A stimulus trigger starts a capacitor
* charging through a resistor. When the subject responds
* (presses a button), the charging stops. The voltage on
* the capacitor is proportional to the elapsed time.
*
* This models Ham's lever-pull task during MR-2:
*   - Light stimulus appears → timer starts
*   - Ham pulls lever → timer stops
*   - Voltage on capacitor = reaction time
*
* Ham's performance:
*   Ground training baseline: ~400 ms
*   In-flight performance:    ~500 ms
*   Despite up to 14.7g reentry forces
*
* The RC time constant is chosen so that:
*   V(cap) at 400 ms ≈ 3.3V (baseline)
*   V(cap) at 500 ms ≈ 3.9V (flight)
*   V(cap) at 1000 ms ≈ 6.3V (slow response)
*   Full scale (5τ) ≈ 5 seconds
*
* Run: ngspice -b reaction-timer.cir

*--------------------------------------------------------------
* POWER SUPPLY
*--------------------------------------------------------------
V_supply  vcc  0  DC 10

*--------------------------------------------------------------
* STIMULUS GENERATOR
*--------------------------------------------------------------
* Periodic stimulus pulse (like Ham's light panel)
* Stimulus appears for 100 ms every 3 seconds
V_stimulus  stim_out  0  PULSE(0 5 0.5 1m 1m 100m 3)

* Stimulus LED driver
R_stim_led  stim_out  stim_led  470
* (LED between stim_led and GND in physical circuit)

*--------------------------------------------------------------
* TRIAL 1: GROUND BASELINE (400 ms reaction time)
*--------------------------------------------------------------

.subckt TRIAL  timer_out  response_time  gnd  stim_in

  * RC timing circuit
  * When stimulus activates, switch closes and cap begins charging
  * through R_time. V(cap) is proportional to elapsed time.
  R_time  vcc_local  cap_node  1MEG
  C_time  cap_node  gnd  1u
  * τ = 1MΩ × 1µF = 1 second
  * V(400ms) = 10 × (1 - e^(-0.4/1.0)) = 3.30V
  * V(500ms) = 10 × (1 - e^(-0.5/1.0)) = 3.93V

  * Stimulus activates the charging (closes switch)
  V_local  vcc_local  gnd  DC 10
  S_start  vcc_local  charge_src  stim_in  gnd  SW_START
  R_charge  charge_src  cap_node  1MEG

  * Response stops charging (opens switch / discharges)
  * Simulated as a timed switch that opens at response_time
  * In physical circuit: button press opens the charge path
  R_resp  cap_node  resp_node  100
  S_response  resp_node  gnd  resp_ctrl  gnd  SW_STOP
  V_resp_ctrl  resp_ctrl  gnd  PWL(0 0  0.49 0  0.50 0  0.90 0  0.91 5  3.0 5)

  * Reset between trials (discharge cap)
  * After stimulus ends, reset the capacitor for next trial
  R_reset  cap_node  reset_node  100
  S_reset  reset_node  gnd  reset_ctrl  gnd  SW_STOP
  V_reset_ctrl  reset_ctrl  gnd  PWL(0 0  2.5 0  2.6 5  2.9 5  3.0 0)

  * Output: voltage = reaction time
  R_out  cap_node  timer_out  100

.ends

*--------------------------------------------------------------
* BASELINE TRIAL: 400 ms response
*--------------------------------------------------------------
.subckt BASELINE  timer_out  gnd

  R_time  v_src  cap_node  1MEG
  V_src  v_src  gnd  DC 10
  C_time  cap_node  gnd  1u
  * τ = 1s, so V(0.4s) = 10*(1-exp(-0.4)) = 3.30V

  * Start charging at T=0.5s (stimulus onset)
  S_start  v_src  start_out  start_ctrl  gnd  SW_ON
  V_start  start_ctrl  gnd  PWL(0 0  0.49 0  0.50 5  10 5)
  R_start  start_out  cap_node  1MEG

  * Stop charging at T=0.9s (400 ms response)
  S_stop  cap_node  gnd  stop_ctrl  gnd  SW_ON
  V_stop  stop_ctrl  gnd  PWL(0 0  0.89 0  0.90 5  10 5)
  R_stop  cap_node  stop_out  10MEG
  * Actually: just disconnect the charging source at T=0.9s
  * Use a second switch to isolate the cap

  R_out  cap_node  timer_out  100

.ends

X_baseline  baseline_out  0  BASELINE

*--------------------------------------------------------------
* FLIGHT TRIAL: 500 ms response (degraded by g-forces)
*--------------------------------------------------------------
.subckt FLIGHT  timer_out  gnd

  R_time  v_src  cap_node  1MEG
  V_src  v_src  gnd  DC 10
  C_time  cap_node  gnd  1u

  * Start charging at T=0.5s
  S_start  v_src  start_out  start_ctrl  gnd  SW_ON
  V_start  start_ctrl  gnd  PWL(0 0  0.49 0  0.50 5  10 5)
  R_start  start_out  cap_node  1MEG

  * Stop charging at T=1.0s (500 ms response — 100ms slower)
  S_stop  cap_node  gnd  stop_ctrl  gnd  SW_ON
  V_stop  stop_ctrl  gnd  PWL(0 0  0.99 0  1.00 5  10 5)
  R_stop  cap_node  stop_out  10MEG

  R_out  cap_node  timer_out  100

.ends

X_flight  flight_out  0  FLIGHT

*--------------------------------------------------------------
* MODELS
*--------------------------------------------------------------
.model SW_START SW(RON=1 ROFF=10MEG VT=2.5 VH=0.5)
.model SW_STOP  SW(RON=1 ROFF=10MEG VT=2.5 VH=0.5)
.model SW_ON    SW(RON=100 ROFF=10MEG VT=2.5 VH=0.5)

*--------------------------------------------------------------
* ANALYSIS
*--------------------------------------------------------------
.tran 1m 3

*--------------------------------------------------------------
* CONTROL
*--------------------------------------------------------------
.control
  run
  set hcopydevtype = svg

  * Plot 1: Stimulus signal
  plot V(stim_out)
+   title 'Stimulus Signal (Light Flash)'
+   xlabel 'Time (s)' ylabel 'Voltage (V)'

  * Plot 2: Reaction time comparison
  plot V(baseline_out) V(flight_out)
+   title 'Reaction Time: Baseline (400ms) vs Flight (500ms)'
+   xlabel 'Time (s)' ylabel 'Capacitor Voltage (V)'

  * Show the voltage difference = time difference
  * At 400ms: V ≈ 3.3V. At 500ms: V ≈ 3.9V.
  * Difference of 0.6V represents 100ms degradation.

  echo ""
  echo "=== Reaction Time Measurement ==="
  echo "RC time constant: 1 MΩ × 1 µF = 1 second"
  echo "V(t) = 10 × (1 - exp(-t/RC))"
  echo "Baseline (400ms): V = 10 × (1 - exp(-0.4)) = 3.30V"
  echo "Flight   (500ms): V = 10 × (1 - exp(-0.5)) = 3.93V"
  echo "Degradation: +100ms (+25%), consistent with g-force effects"
  echo ""
.endc

.end
